* Numerically resolved schematic reference
.subckt device_coupon P N
* IC Design Studio / Untitled circuit / revision 0
* design-sha256 e049dcd72086178acc8b11098156b1f4a9d937da886b8907817cbf99af31a96f
* Explicit locked PDK model bindings. Qualification depends on the validated reference flow.
R_R1 P N sky130_fd_pr__res_generic_po l=20 m=1 w=1
X_MDUMMY N N N N sky130_fd_pr__nfet_01v8 ad=0.29 as=0.29 l=1 m=1 mult=1 nf=1 nrd=0.29 nrs=0.29 pd=2.58 ps=2.58 sa=0 sb=0 sd=0 w=1
.ends device_coupon
