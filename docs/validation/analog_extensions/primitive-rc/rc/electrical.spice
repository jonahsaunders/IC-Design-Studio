* NGSPICE file created from device_coupon.ext - technology: sky130A

.subckt device_coupon P N
RSTUDIO_DEVICE_660e7f6b3a063feb05c0 P.t0 N.t4 sky130_fd_pr__res_generic_po w=1 l=20
X0 N.t3 N.t0 N.t2 N.t1 sky130_fd_pr__nfet_01v8 ad=0.8 pd=3.6 as=1.6000000000000001 ps=7.2000000000000002 w=1 l=1
R0 P P.t0 233.59999999999999
R1 N N.n0 2.2985000000000002
R2 N.n2 N.n1 0.367647
R3 N.n0 N.n2 1.3597900000000001
R4 N.n0 N.t1 4812.3500000000004
R5 N.n2 N.t2 255.083
R6 N.n1 N.t0 214.69900000000001
R7 N.n1 N.t3 255.80199999999999
R8 N N.t4 233.59999999999999
C_STUDIO_RC_0 P N 5.7624400000000004e-16
.ends
