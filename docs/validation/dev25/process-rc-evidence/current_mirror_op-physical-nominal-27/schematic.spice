* Numerically resolved schematic reference
.subckt current_mirror IREF OUT VSS
* IC Design Studio / Current mirror · SkyWater SKY130 · sky130A / revision 0
* design-sha256 6abb5239dc86a791863c12601989f8206e1b100e5105c80947f834eb5886de1e
* Explicit locked PDK model bindings. Qualification depends on the validated reference flow.
X_MREF IREF IREF VSS VSS sky130_fd_pr__nfet_01v8 ad=2.9 as=2.9 l=1 m=1 mult=1 nf=1 nrd=0.029 nrs=0.029 pd=20.58 ps=20.58 sa=0 sb=0 sd=0 w=10
X_MOUT OUT IREF VSS VSS sky130_fd_pr__nfet_01v8 ad=2.9 as=2.9 l=1 m=1 mult=1 nf=1 nrd=0.029 nrs=0.029 pd=20.58 ps=20.58 sa=0 sb=0 sd=0 w=10
.ends current_mirror
