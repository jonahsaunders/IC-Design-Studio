* NGSPICE file created from device_coupon.ext - technology: sky130A

.subckt device_coupon P N
X0 P N sky130_fd_pr__cap_mim_m3_1 l=10 w=10
.ends
