* Numerically resolved schematic reference
.subckt device_coupon VREF
* IC Design Studio / Untitled circuit / revision 0
* design-sha256 c01c39c50914aff257232acbeffab5fc07502e8308c11d502eb1f1e7d17142f7
* Explicit locked PDK model bindings. Qualification depends on the validated reference flow.
X_MDUMMY VREF VREF VREF VREF sky130_fd_pr__pfet_01v8 ad=8.7 as=8.7 l=0.5 m=1 mult=1 nf=1 nrd=0.00966666666667 nrs=0.00966666666667 pd=60.58 ps=60.58 sa=0 sb=0 sd=0 w=30
.ends device_coupon
