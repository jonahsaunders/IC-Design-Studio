* Numerically resolved schematic reference
.subckt device_coupon VREF
* IC Design Studio / Untitled circuit / revision 0
* design-sha256 a745f82d1c58a799e8cc23fc6b9b0c6e85d35f4ac56be4ce396fc0cb11cad739
* Explicit locked PDK model bindings. Qualification depends on the validated reference flow.
X_MDUMMY VREF VREF VREF VREF sky130_fd_pr__pfet_01v8 ad=0.58 as=0.58 l=1 m=1 mult=1 nf=1 nrd=0.145 nrs=0.145 pd=4.58 ps=4.58 sa=0 sb=0 sd=0 w=2
.ends device_coupon
