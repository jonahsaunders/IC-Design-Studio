* Absolute distributed-capacitance conservation probe
R1 IN IN.t0 279.777
C_STUDIO_RC_0 IN.t0 0 3.120967642542085e-16
C_STUDIO_RC_1 IN 0 1.0827003235745794e-14
C_STUDIO_RC_4 0 IN.t0 1.5687071427520067e-19
C_STUDIO_RC_5 0 IN 5.4420292857247994e-18
C_STUDIO_RC_6 0 IN.t0 8.297317365227492e-20
C_STUDIO_RC_7 0 IN 2.8784368263477254e-18
VDRIVE IN 0 AC 1
.ac lin 2 1000 1001
.save i(vdrive) v(IN.t0)
.end
