* NGSPICE file created from rc_coupon.ext - technology: sky130A

.subckt rc_coupon IN DRAIN VSS
X0 DRAIN.t0 IN.t0 VSS.t1 VSS.t0 sky130_fd_pr__nfet_01v8 ad=0.8 pd=3.6 as=0.8 ps=3.6 w=1 l=0.5
R0 DRAIN DRAIN.t0 254.3
R1 IN IN.t0 279.777
R2 VSS VSS.t0 5670.97
R3 VSS VSS.t1 254.925
C_STUDIO_RC_0 IN.t0 VSS 3.1209676425420851e-16
C_STUDIO_RC_1 IN VSS 1.0827003235745794e-14
C_STUDIO_RC_2 DRAIN.t0 VSS 6.384012639845987e-17
C_STUDIO_RC_3 DRAIN VSS 3.3766773601540131e-17
C_STUDIO_RC_4 DRAIN.t0 IN.t0 1.5687071427520067e-19
C_STUDIO_RC_5 DRAIN.t0 IN 5.4420292857247994e-18
C_STUDIO_RC_6 DRAIN IN.t0 8.2973173652274923e-20
C_STUDIO_RC_7 DRAIN IN 2.8784368263477254e-18
.ends
