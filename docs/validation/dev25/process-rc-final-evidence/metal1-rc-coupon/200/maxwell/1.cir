* Independent full terminal capacitance matrix
R0 DRAIN DRAIN.t0 254.3
R1 IN IN.t0 292.277
R2 VSS VSS.t0 5670.97
R3 VSS VSS.t1 254.925
C_STUDIO_RC_0 IN.t0 VSS 9.93365323444911e-16
C_STUDIO_RC_1 IN VSS 2.083773467655509e-14
C_STUDIO_RC_2 DRAIN.t0 VSS 6.384012639845987e-17
C_STUDIO_RC_3 DRAIN VSS 3.376677360154013e-17
C_STUDIO_RC_4 DRAIN.t0 IN.t0 2.547628433489706e-19
C_STUDIO_RC_5 DRAIN.t0 IN 5.344137156651029e-18
C_STUDIO_RC_6 DRAIN IN.t0 1.3475097464181806e-19
C_STUDIO_RC_7 DRAIN IN 2.8266590253581816e-18
V0 IN 0 AC 0
V1 DRAIN 0 AC 1
V2 VSS 0 AC 0
.ac lin 2 1000 1001
.save i(v0) i(v1) i(v2) v(DRAIN)
.end
