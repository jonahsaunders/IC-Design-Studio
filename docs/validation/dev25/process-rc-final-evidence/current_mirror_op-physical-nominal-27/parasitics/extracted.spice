* NGSPICE file created from current_mirror.ext - technology: sky130A

.subckt current_mirror IREF OUT VSS
X0 IREF.t1 IREF.t0 VSS.t1 VSS.t0 sky130_fd_pr__nfet_01v8 ad=8 pd=21.6 as=8 ps=21.6 w=10 l=1
X1 OUT.t0 IREF.t2 VSS.t3 VSS.t2 sky130_fd_pr__nfet_01v8 ad=8 pd=21.6 as=8 ps=21.6 w=10 l=1
R0 OUT OUT.t0 220.72
R1 IREF.n0 IREF.t2 449.103
R2 IREF.n1 IREF.t0 440.647
R3 IREF.n0 IREF.t1 207.668
R4 IREF IREF.n1 2.39021
R5 IREF.n1 IREF.n0 0.368147
R6 VSS.t0 VSS.n2 4301.06
R7 VSS.n3 VSS.t0 1734.81
R8 VSS.n2 VSS.n1 1189.61
R9 VSS.n2 VSS.t2 545.205
R10 VSS.n1 VSS.t3 211.234
R11 VSS.n0 VSS.t1 210.609
R12 VSS.n1 VSS.n0 8.19903
R13 VSS VSS.n3 1.39756
R14 VSS.n3 VSS.n0 0.6255
C_STUDIO_RC_0 IREF.t2 VSS 9.8494655433431123e-16
C_STUDIO_RC_1 IREF.t1 VSS 8.657816686935665e-16
C_STUDIO_RC_2 IREF.n0 VSS 2.3792899251812413e-15
C_STUDIO_RC_3 IREF.t0 VSS 9.540263417671929e-16
C_STUDIO_RC_4 IREF.n1 VSS 8.5336538543635352e-16
C_STUDIO_RC_5 IREF VSS 1.2065012458733557e-16
C_STUDIO_RC_6 OUT.t0 VSS 1.2202135481521812e-15
C_STUDIO_RC_7 OUT VSS 2.5902064518478189e-15
C_STUDIO_RC_8 IREF.t2 OUT.t0 6.0204951301235584e-17
C_STUDIO_RC_9 IREF.t2 OUT 1.2779996872661782e-16
C_STUDIO_RC_10 IREF.t1 OUT.t0 5.2920986394462329e-17
C_STUDIO_RC_11 IREF.t1 OUT 1.1233794330891271e-16
C_STUDIO_RC_12 IREF.n0 OUT.t0 1.4543432173725509e-16
C_STUDIO_RC_13 IREF.n0 OUT 3.0872048507772196e-16
C_STUDIO_RC_14 IREF.t0 OUT.t0 5.831495038328184e-17
C_STUDIO_RC_15 IREF.t0 OUT 1.2378797215511973e-16
C_STUDIO_RC_16 IREF.n1 OUT.t0 5.2162039905890597e-17
C_STUDIO_RC_17 IREF.n1 OUT 1.1072689080561712e-16
C_STUDIO_RC_18 IREF OUT.t0 7.3747502778745498e-18
C_STUDIO_RC_19 IREF OUT 1.5654739926010717e-17
.ends
