* NGSPICE file created from current_mirror.ext - technology: sky130A

.subckt current_mirror IREF OUT VSS
X0 IREF.t1 IREF.t0 VSS.t1 VSS.t0 sky130_fd_pr__nfet_01v8 ad=8 pd=21.6 as=8 ps=21.6 w=10 l=1
X1 OUT.t0 IREF.t2 VSS.t3 VSS.t2 sky130_fd_pr__nfet_01v8 ad=8 pd=21.6 as=8 ps=21.6 w=10 l=1
R0 OUT OUT.t0 220.72
R1 IREF.n0 IREF.t2 449.103
R2 IREF.n1 IREF.t0 440.647
R3 IREF.n0 IREF.t1 207.668
R4 IREF IREF.n1 2.39021
R5 IREF.n1 IREF.n0 0.368147
R6 VSS.t0 VSS.n2 4301.06
R7 VSS.n3 VSS.t0 1734.81
R8 VSS.n2 VSS.n1 1189.61
R9 VSS.n2 VSS.t2 545.205
R10 VSS.n1 VSS.t3 211.234
R11 VSS.n0 VSS.t1 210.609
R12 VSS.n1 VSS.n0 8.19903
R13 VSS VSS.n3 1.39756
R14 VSS.n3 VSS.n0 0.6255
C0 IREF.t1 OUT.t0 0.05292f
C1 IREF.n0 OUT.t0 0.14543f
C2 IREF OUT.t0 0.00737f
C3 IREF.t2 OUT 0.1278f
C4 IREF.t0 OUT.t0 0.05831f
C5 IREF.n1 OUT 0.11073f
C6 IREF.t2 OUT.t0 0.0602f
C7 IREF.t1 OUT 0.11234f
C8 IREF.n0 OUT 0.30872f
C9 IREF OUT 0.01565f
C10 IREF.n1 OUT.t0 0.05216f
C11 IREF.t0 OUT 0.12379f
C12 OUT VSS 2.59021f
C13 IREF VSS 0.12065f
C14 IREF.t2 VSS 0.98495f
C15 IREF.t1 VSS 0.86578f
C16 IREF.n0 VSS 2.37929f
C17 IREF.t0 VSS 0.95403f
C18 IREF.n1 VSS 0.85337f
C19 OUT.t0 VSS 1.22021f
.ends
