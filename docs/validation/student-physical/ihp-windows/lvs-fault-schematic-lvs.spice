* Numerically resolved schematic reference
.subckt inverter A Y VPWR VGND
* IC Design Studio / Student inverter · ihp-sg13g2 · 3abac20fcb57e184 / revision 0
* design-sha256 7bce229142bbdb5dd7bb89c10fa433d0720168e3d4dcc6fdd881b762837c552c
* Explicit locked PDK model bindings. Qualification depends on the validated reference flow.
X_MN Y A VGND VGND sg13_lv_nmos w=1.3e-06 l=1.3e-07 ng=1 m=1
X_MP Y A VPWR VPWR sg13_lv_pmos w=2e-06 l=1.3e-07 ng=1 m=1
.ends inverter
