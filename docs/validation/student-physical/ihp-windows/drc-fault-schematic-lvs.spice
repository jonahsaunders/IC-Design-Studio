* Numerically resolved schematic reference
.subckt inverter A Y VPWR VGND
* IC Design Studio / Student inverter · ihp-sg13g2 · 3abac20fcb57e184 / revision 0
* design-sha256 b0cfa053a3f11008c068bd0ca8592e9c3bbaf94900ea20a3534f8de737097cdf
* Explicit locked PDK model bindings. Qualification depends on the validated reference flow.
X_MN Y A VGND VGND sg13_lv_nmos w=1e-06 l=1.3e-07 ng=1 m=1
X_MP Y A VPWR VPWR sg13_lv_pmos w=2e-06 l=1.3e-07 ng=1 m=1
.ends inverter
