* Extracted by KLayout with GF180MCU LVS runset on : 21/09/2026 21:33

.SUBCKT banba_layout VSS VREF VDD
M$1 \$661218 \$691330 VDD VDD pfet_03v3 L=8U W=1U AS=0.8P AD=0.8P PS=3.6U
+ PD=3.6U
M$2 \$668316 \$668316 VDD VDD pfet_03v3 L=4U W=4U AS=3.2P AD=3.2P PS=9.6U
+ PD=9.6U
M$3 \$691330 \$668316 VDD VDD pfet_03v3 L=8U W=4U AS=3.2P AD=3.2P PS=9.6U
+ PD=9.6U
M$4 \$711816 \$691330 VDD VDD pfet_03v3 L=4U W=8U AS=6.4P AD=6.4P PS=17.6U
+ PD=17.6U
M$5 \$687255 \$691330 VDD VDD pfet_03v3 L=4U W=8U AS=6.4P AD=6.4P PS=17.6U
+ PD=17.6U
M$6 VREF \$691330 VDD VDD pfet_03v3 L=4U W=8U AS=6.4P AD=6.4P PS=17.6U PD=17.6U
M$7 \$663965 \$668316 VDD VDD pfet_03v3 L=4U W=8U AS=6.4P AD=6.4P PS=17.6U
+ PD=17.6U
M$8 \$670454 \$711816 \$663965 VDD pfet_03v3 L=2U W=24U AS=19.2P AD=19.2P
+ PS=49.6U PD=49.6U
M$9 \$672593 \$687255 \$663965 VDD pfet_03v3 L=2U W=24U AS=19.2P AD=19.2P
+ PS=49.6U PD=49.6U
M$10 \$691330 \$658064 VSS VSS nfet_03v3 L=4U W=0.5U AS=0.4P AD=0.4P PS=2.6U
+ PD=2.6U
M$11 \$670454 \$670454 VSS VSS nfet_03v3 L=2U W=4U AS=3.2P AD=3.2P PS=9.6U
+ PD=9.6U
M$12 \$672593 \$670454 VSS VSS nfet_03v3 L=2U W=4U AS=3.2P AD=3.2P PS=9.6U
+ PD=9.6U
M$13 \$691330 \$672593 VSS VSS nfet_03v3 L=2U W=4U AS=3.2P AD=3.2P PS=9.6U
+ PD=9.6U
M$14 \$658064 \$661218 VSS VSS nfet_03v3 L=1U W=8U AS=6.4P AD=6.4P PS=17.6U
+ PD=17.6U
Q$15 VSS VSS \$701294 pnp_05p00x05p00 AE=25P PE=20U AB=41.9904P PB=25.92U
+ AC=41.9904P PC=25.92U NE=1
Q$16 VSS VSS \$701294 pnp_05p00x05p00 AE=25P PE=20U AB=41.9904P PB=25.92U
+ AC=41.9904P PC=25.92U NE=1
Q$17 VSS VSS \$701294 pnp_05p00x05p00 AE=25P PE=20U AB=41.9904P PB=25.92U
+ AC=41.9904P PC=25.92U NE=1
Q$18 VSS VSS \$701294 pnp_05p00x05p00 AE=25P PE=20U AB=41.9904P PB=25.92U
+ AC=41.9904P PC=25.92U NE=1
Q$19 VSS VSS \$701294 pnp_05p00x05p00 AE=25P PE=20U AB=41.9904P PB=25.92U
+ AC=41.9904P PC=25.92U NE=1
Q$20 VSS VSS \$711816 pnp_05p00x05p00 AE=25P PE=20U AB=41.9904P PB=25.92U
+ AC=41.9904P PC=25.92U NE=1
Q$21 VSS VSS \$701294 pnp_05p00x05p00 AE=25P PE=20U AB=41.9904P PB=25.92U
+ AC=41.9904P PC=25.92U NE=1
Q$22 VSS VSS \$701294 pnp_05p00x05p00 AE=25P PE=20U AB=41.9904P PB=25.92U
+ AC=41.9904P PC=25.92U NE=1
Q$23 VSS VSS \$701294 pnp_05p00x05p00 AE=25P PE=20U AB=41.9904P PB=25.92U
+ AC=41.9904P PC=25.92U NE=1
R$24 \$711816 VSS VSS 100000 ppolyf_u_1k L=100U W=1U
R$25 \$687255 VSS VSS 100000 ppolyf_u_1k L=100U W=1U
R$26 \$746807 \$744748 VSS 100000 ppolyf_u_1k L=100U W=1U
R$27 \$746807 \$750967 VSS 100000 ppolyf_u_1k L=100U W=1U
R$28 \$661218 \$744748 VSS 100000 ppolyf_u_1k L=100U W=1U
R$29 \$753049 \$750967 VSS 100000 ppolyf_u_1k L=100U W=1U
R$30 \$753049 \$755128 VSS 100000 ppolyf_u_1k L=100U W=1U
R$31 \$687255 \$701294 VSS 10850 ppolyf_u_1k L=10.85U W=1U
R$32 VREF VSS VSS 50150 ppolyf_u_1k L=50.15U W=1U
R$33 \$757210 \$755128 VSS 100000 ppolyf_u_1k L=100U W=1U
R$34 \$757210 \$761396 VSS 100000 ppolyf_u_1k L=100U W=1U
R$35 \$763475 \$765557 VSS 100000 ppolyf_u_1k L=100U W=1U
R$36 \$763475 \$761396 VSS 100000 ppolyf_u_1k L=100U W=1U
R$37 \$767642 \$765557 VSS 100000 ppolyf_u_1k L=100U W=1U
R$38 \$668316 \$771831 VSS 100000 ppolyf_u_1k L=100U W=1U
R$39 \$767642 \$771832 VSS 100000 ppolyf_u_1k L=100U W=1U
R$40 \$773917 \$771831 VSS 100000 ppolyf_u_1k L=100U W=1U
R$41 \$773918 \$771832 VSS 100000 ppolyf_u_1k L=100U W=1U
R$42 \$773917 \$776001 VSS 100000 ppolyf_u_1k L=100U W=1U
R$43 \$773918 \$776002 VSS 100000 ppolyf_u_1k L=100U W=1U
R$44 \$778087 \$776001 VSS 100000 ppolyf_u_1k L=100U W=1U
R$45 \$778088 \$776002 VSS 100000 ppolyf_u_1k L=100U W=1U
R$46 \$778087 \$782253 VSS 100000 ppolyf_u_1k L=100U W=1U
R$47 \$778088 \$782254 VSS 100000 ppolyf_u_1k L=100U W=1U
R$48 \$784337 \$782253 VSS 100000 ppolyf_u_1k L=100U W=1U
R$49 VSS \$782254 VSS 100000 ppolyf_u_1k L=100U W=1U
R$50 \$784337 \$786422 VSS 100000 ppolyf_u_1k L=100U W=1U
R$51 \$788524 \$786422 VSS 100000 ppolyf_u_1k L=100U W=1U
R$52 \$788524 \$792688 VSS 100000 ppolyf_u_1k L=100U W=1U
R$53 VSS \$792688 VSS 100000 ppolyf_u_1k L=100U W=1U
R$54 VDD \$796853 VSS 100000 ppolyf_u_1k L=100U W=1U
R$55 \$798937 \$796853 VSS 100000 ppolyf_u_1k L=100U W=1U
R$56 \$798937 \$803101 VSS 100000 ppolyf_u_1k L=100U W=1U
R$57 \$805183 \$803101 VSS 100000 ppolyf_u_1k L=100U W=1U
R$58 \$805183 \$807287 VSS 100000 ppolyf_u_1k L=100U W=1U
R$59 \$809369 \$807287 VSS 100000 ppolyf_u_1k L=100U W=1U
R$60 \$809369 \$813537 VSS 100000 ppolyf_u_1k L=100U W=1U
R$61 \$815627 \$813537 VSS 100000 ppolyf_u_1k L=100U W=1U
R$62 \$815627 \$817734 VSS 100000 ppolyf_u_1k L=100U W=1U
R$63 \$819860 \$817734 VSS 100000 ppolyf_u_1k L=100U W=1U
R$64 \$819860 \$824107 VSS 100000 ppolyf_u_1k L=100U W=1U
R$65 \$826230 \$824107 VSS 100000 ppolyf_u_1k L=100U W=1U
R$66 \$826230 \$828376 VSS 100000 ppolyf_u_1k L=100U W=1U
R$67 \$830499 \$828376 VSS 100000 ppolyf_u_1k L=100U W=1U
R$68 \$830499 \$834746 VSS 100000 ppolyf_u_1k L=100U W=1U
R$69 \$836897 \$834746 VSS 100000 ppolyf_u_1k L=100U W=1U
R$70 \$836897 \$839020 VSS 100000 ppolyf_u_1k L=100U W=1U
R$71 \$841146 \$839020 VSS 100000 ppolyf_u_1k L=100U W=1U
R$72 \$841146 \$845393 VSS 100000 ppolyf_u_1k L=100U W=1U
R$73 \$658064 \$845393 VSS 100000 ppolyf_u_1k L=100U W=1U
C$74 VSS VREF 1.67445e-11 cap_mim_2f0_m3m4_noshield A=8372.25P P=366U
C$75 VSS VREF 1.67445e-11 cap_mim_2f0_m3m4_noshield A=8372.25P P=366U
C$76 VSS VREF 1.67445e-11 cap_mim_2f0_m3m4_noshield A=8372.25P P=366U
C$77 VSS VREF 1.67445e-11 cap_mim_2f0_m3m4_noshield A=8372.25P P=366U
C$78 VSS VREF 1.67445e-11 cap_mim_2f0_m3m4_noshield A=8372.25P P=366U
C$79 VSS VREF 1.67445e-11 cap_mim_2f0_m3m4_noshield A=8372.25P P=366U
C$80 VSS VREF 1.67445e-11 cap_mim_2f0_m3m4_noshield A=8372.25P P=366U
C$81 VSS VREF 1.67445e-11 cap_mim_2f0_m3m4_noshield A=8372.25P P=366U
C$82 VSS VREF 1.67445e-11 cap_mim_2f0_m3m4_noshield A=8372.25P P=366U
C$83 VSS VREF 1.67445e-11 cap_mim_2f0_m3m4_noshield A=8372.25P P=366U
C$84 VSS VREF 1.67445e-11 cap_mim_2f0_m3m4_noshield A=8372.25P P=366U
C$85 VSS VREF 1.67445e-11 cap_mim_2f0_m3m4_noshield A=8372.25P P=366U
C$86 VSS VREF 1.67445e-11 cap_mim_2f0_m3m4_noshield A=8372.25P P=366U
C$87 VSS VREF 1.67445e-11 cap_mim_2f0_m3m4_noshield A=8372.25P P=366U
C$88 VSS VREF 1.67445e-11 cap_mim_2f0_m3m4_noshield A=8372.25P P=366U
C$89 \$691330 \$672593 3.9997568e-12 cap_mim_2f0_m3m4_noshield A=1999.8784P
+ P=178.88U
C$90 \$691330 VDD 1.86901778e-11 cap_mim_2f0_m3m4_noshield A=9345.0889P
+ P=386.68U
C$91 \$691330 VDD 1.86901778e-11 cap_mim_2f0_m3m4_noshield A=9345.0889P
+ P=386.68U
C$92 VSS VREF 1.67445e-11 cap_mim_2f0_m3m4_noshield A=8372.25P P=366U
C$93 VSS VREF 1.67445e-11 cap_mim_2f0_m3m4_noshield A=8372.25P P=366U
C$94 VSS VREF 1.67445e-11 cap_mim_2f0_m3m4_noshield A=8372.25P P=366U
C$95 VSS VREF 1.67445e-11 cap_mim_2f0_m3m4_noshield A=8372.25P P=366U
C$96 VSS VREF 1.67445e-11 cap_mim_2f0_m3m4_noshield A=8372.25P P=366U
C$97 \$691330 VDD 1.86901778e-11 cap_mim_2f0_m3m4_noshield A=9345.0889P
+ P=386.68U
C$98 \$691330 VDD 1.86901778e-11 cap_mim_2f0_m3m4_noshield A=9345.0889P
+ P=386.68U
C$99 VSS VREF 1.67445e-11 cap_mim_2f0_m3m4_noshield A=8372.25P P=366U
C$100 VSS VREF 1.67445e-11 cap_mim_2f0_m3m4_noshield A=8372.25P P=366U
C$101 VSS VREF 1.67445e-11 cap_mim_2f0_m3m4_noshield A=8372.25P P=366U
C$102 VSS VREF 1.67445e-11 cap_mim_2f0_m3m4_noshield A=8372.25P P=366U
C$103 VSS VREF 1.67445e-11 cap_mim_2f0_m3m4_noshield A=8372.25P P=366U
.ENDS banba_layout
