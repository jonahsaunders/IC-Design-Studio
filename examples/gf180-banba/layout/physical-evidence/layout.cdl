* Extracted by KLayout with GF180MCU LVS runset on : 21/09/2026 17:01

.SUBCKT banba_layout VSS VREF VDD
M$1 \$2 \$21 VDD VDD pfet_03v3 L=8U W=1U AS=0.8P AD=0.8P PS=3.6U PD=3.6U
M$2 \$3 \$3 VDD VDD pfet_03v3 L=4U W=4U AS=3.2P AD=3.2P PS=9.6U PD=9.6U
M$3 \$21 \$3 VDD VDD pfet_03v3 L=8U W=4U AS=3.2P AD=3.2P PS=9.6U PD=9.6U
M$4 \$100 \$21 VDD VDD pfet_03v3 L=4U W=8U AS=6.4P AD=6.4P PS=17.6U PD=17.6U
M$5 \$20 \$21 VDD VDD pfet_03v3 L=4U W=8U AS=6.4P AD=6.4P PS=17.6U PD=17.6U
M$6 VREF \$21 VDD VDD pfet_03v3 L=4U W=8U AS=6.4P AD=6.4P PS=17.6U PD=17.6U
M$7 \$28 \$3 VDD VDD pfet_03v3 L=4U W=8U AS=6.4P AD=6.4P PS=17.6U PD=17.6U
M$8 \$5 \$100 \$28 VDD pfet_03v3 L=2U W=24U AS=19.2P AD=19.2P PS=49.6U PD=49.6U
M$9 \$4 \$20 \$28 VDD pfet_03v3 L=2U W=24U AS=19.2P AD=19.2P PS=49.6U PD=49.6U
M$10 \$21 \$1 VSS VSS nfet_03v3 L=4U W=0.5U AS=0.4P AD=0.4P PS=2.6U PD=2.6U
M$11 \$5 \$5 VSS VSS nfet_03v3 L=2U W=4U AS=3.2P AD=3.2P PS=9.6U PD=9.6U
M$12 \$4 \$5 VSS VSS nfet_03v3 L=2U W=4U AS=3.2P AD=3.2P PS=9.6U PD=9.6U
M$13 \$21 \$4 VSS VSS nfet_03v3 L=2U W=4U AS=3.2P AD=3.2P PS=9.6U PD=9.6U
M$14 \$1 \$2 VSS VSS nfet_03v3 L=1U W=8U AS=6.4P AD=6.4P PS=17.6U PD=17.6U
Q$15 VSS VSS \$33 pnp_05p00x05p00 AE=25P PE=20U AB=41.9904P PB=25.92U
+ AC=41.9904P PC=25.92U NE=1
Q$16 VSS VSS \$33 pnp_05p00x05p00 AE=25P PE=20U AB=41.9904P PB=25.92U
+ AC=41.9904P PC=25.92U NE=1
Q$17 VSS VSS \$33 pnp_05p00x05p00 AE=25P PE=20U AB=41.9904P PB=25.92U
+ AC=41.9904P PC=25.92U NE=1
Q$18 VSS VSS \$33 pnp_05p00x05p00 AE=25P PE=20U AB=41.9904P PB=25.92U
+ AC=41.9904P PC=25.92U NE=1
Q$19 VSS VSS \$33 pnp_05p00x05p00 AE=25P PE=20U AB=41.9904P PB=25.92U
+ AC=41.9904P PC=25.92U NE=1
Q$20 VSS VSS \$100 pnp_05p00x05p00 AE=25P PE=20U AB=41.9904P PB=25.92U
+ AC=41.9904P PC=25.92U NE=1
Q$21 VSS VSS \$33 pnp_05p00x05p00 AE=25P PE=20U AB=41.9904P PB=25.92U
+ AC=41.9904P PC=25.92U NE=1
Q$22 VSS VSS \$33 pnp_05p00x05p00 AE=25P PE=20U AB=41.9904P PB=25.92U
+ AC=41.9904P PC=25.92U NE=1
Q$23 VSS VSS \$33 pnp_05p00x05p00 AE=25P PE=20U AB=41.9904P PB=25.92U
+ AC=41.9904P PC=25.92U NE=1
R$24 \$100 VSS VSS 100000 ppolyf_u_1k L=100U W=1U
R$25 \$20 VSS VSS 100000 ppolyf_u_1k L=100U W=1U
R$26 \$145 \$148 VSS 100000 ppolyf_u_1k L=100U W=1U
R$27 \$145 \$150 VSS 100000 ppolyf_u_1k L=100U W=1U
R$28 \$2 \$148 VSS 100000 ppolyf_u_1k L=100U W=1U
R$29 \$146 \$150 VSS 100000 ppolyf_u_1k L=100U W=1U
R$30 \$146 \$152 VSS 100000 ppolyf_u_1k L=100U W=1U
R$31 \$20 \$33 VSS 10850 ppolyf_u_1k L=10.85U W=1U
R$32 VREF VSS VSS 50150 ppolyf_u_1k L=50.15U W=1U
R$33 \$144 \$152 VSS 100000 ppolyf_u_1k L=100U W=1U
R$34 \$144 \$151 VSS 100000 ppolyf_u_1k L=100U W=1U
R$35 \$147 \$149 VSS 100000 ppolyf_u_1k L=100U W=1U
R$36 \$147 \$151 VSS 100000 ppolyf_u_1k L=100U W=1U
R$37 \$221 \$149 VSS 100000 ppolyf_u_1k L=100U W=1U
R$38 \$3 \$220 VSS 100000 ppolyf_u_1k L=100U W=1U
R$39 \$221 \$226 VSS 100000 ppolyf_u_1k L=100U W=1U
R$40 \$217 \$220 VSS 100000 ppolyf_u_1k L=100U W=1U
R$41 \$223 \$226 VSS 100000 ppolyf_u_1k L=100U W=1U
R$42 \$217 \$218 VSS 100000 ppolyf_u_1k L=100U W=1U
R$43 \$223 \$225 VSS 100000 ppolyf_u_1k L=100U W=1U
R$44 \$216 \$218 VSS 100000 ppolyf_u_1k L=100U W=1U
R$45 \$222 \$225 VSS 100000 ppolyf_u_1k L=100U W=1U
R$46 \$216 \$219 VSS 100000 ppolyf_u_1k L=100U W=1U
R$47 \$222 \$224 VSS 100000 ppolyf_u_1k L=100U W=1U
R$48 \$261 \$219 VSS 100000 ppolyf_u_1k L=100U W=1U
R$49 VSS \$224 VSS 100000 ppolyf_u_1k L=100U W=1U
R$50 \$261 \$264 VSS 100000 ppolyf_u_1k L=100U W=1U
R$51 \$262 \$264 VSS 100000 ppolyf_u_1k L=100U W=1U
R$52 \$262 \$263 VSS 100000 ppolyf_u_1k L=100U W=1U
R$53 VSS \$263 VSS 100000 ppolyf_u_1k L=100U W=1U
R$54 VDD \$295 VSS 100000 ppolyf_u_1k L=100U W=1U
R$55 \$292 \$295 VSS 100000 ppolyf_u_1k L=100U W=1U
R$56 \$292 \$294 VSS 100000 ppolyf_u_1k L=100U W=1U
R$57 \$293 \$294 VSS 100000 ppolyf_u_1k L=100U W=1U
R$58 \$293 \$305 VSS 100000 ppolyf_u_1k L=100U W=1U
R$59 \$301 \$305 VSS 100000 ppolyf_u_1k L=100U W=1U
R$60 \$301 \$307 VSS 100000 ppolyf_u_1k L=100U W=1U
R$61 \$304 \$307 VSS 100000 ppolyf_u_1k L=100U W=1U
R$62 \$304 \$308 VSS 100000 ppolyf_u_1k L=100U W=1U
R$63 \$303 \$308 VSS 100000 ppolyf_u_1k L=100U W=1U
R$64 \$303 \$306 VSS 100000 ppolyf_u_1k L=100U W=1U
R$65 \$302 \$306 VSS 100000 ppolyf_u_1k L=100U W=1U
R$66 \$302 \$358 VSS 100000 ppolyf_u_1k L=100U W=1U
R$67 \$357 \$358 VSS 100000 ppolyf_u_1k L=100U W=1U
R$68 \$357 \$359 VSS 100000 ppolyf_u_1k L=100U W=1U
R$69 \$362 \$359 VSS 100000 ppolyf_u_1k L=100U W=1U
R$70 \$362 \$364 VSS 100000 ppolyf_u_1k L=100U W=1U
R$71 \$363 \$364 VSS 100000 ppolyf_u_1k L=100U W=1U
R$72 \$363 \$394 VSS 100000 ppolyf_u_1k L=100U W=1U
R$73 \$1 \$394 VSS 100000 ppolyf_u_1k L=100U W=1U
C$74 VSS VREF 1.67445e-11 cap_mim_2f0_m3m4_noshield A=8372.25P P=366U
C$75 VSS VREF 1.67445e-11 cap_mim_2f0_m3m4_noshield A=8372.25P P=366U
C$76 VSS VREF 1.67445e-11 cap_mim_2f0_m3m4_noshield A=8372.25P P=366U
C$77 VSS VREF 1.67445e-11 cap_mim_2f0_m3m4_noshield A=8372.25P P=366U
C$78 VSS VREF 1.67445e-11 cap_mim_2f0_m3m4_noshield A=8372.25P P=366U
C$79 VSS VREF 1.67445e-11 cap_mim_2f0_m3m4_noshield A=8372.25P P=366U
C$80 VSS VREF 1.67445e-11 cap_mim_2f0_m3m4_noshield A=8372.25P P=366U
C$81 VSS VREF 1.67445e-11 cap_mim_2f0_m3m4_noshield A=8372.25P P=366U
C$82 VSS VREF 1.67445e-11 cap_mim_2f0_m3m4_noshield A=8372.25P P=366U
C$83 VSS VREF 1.67445e-11 cap_mim_2f0_m3m4_noshield A=8372.25P P=366U
C$84 VSS VREF 1.67445e-11 cap_mim_2f0_m3m4_noshield A=8372.25P P=366U
C$85 VSS VREF 1.67445e-11 cap_mim_2f0_m3m4_noshield A=8372.25P P=366U
C$86 VSS VREF 1.67445e-11 cap_mim_2f0_m3m4_noshield A=8372.25P P=366U
C$87 VSS VREF 1.67445e-11 cap_mim_2f0_m3m4_noshield A=8372.25P P=366U
C$88 VSS VREF 1.67445e-11 cap_mim_2f0_m3m4_noshield A=8372.25P P=366U
C$89 \$21 \$4 3.9997568e-12 cap_mim_2f0_m3m4_noshield A=1999.8784P P=178.88U
C$90 \$21 VDD 1.86901778e-11 cap_mim_2f0_m3m4_noshield A=9345.0889P P=386.68U
C$91 \$21 VDD 1.86901778e-11 cap_mim_2f0_m3m4_noshield A=9345.0889P P=386.68U
C$92 VSS VREF 1.67445e-11 cap_mim_2f0_m3m4_noshield A=8372.25P P=366U
C$93 VSS VREF 1.67445e-11 cap_mim_2f0_m3m4_noshield A=8372.25P P=366U
C$94 VSS VREF 1.67445e-11 cap_mim_2f0_m3m4_noshield A=8372.25P P=366U
C$95 VSS VREF 1.67445e-11 cap_mim_2f0_m3m4_noshield A=8372.25P P=366U
C$96 VSS VREF 1.67445e-11 cap_mim_2f0_m3m4_noshield A=8372.25P P=366U
C$97 \$21 VDD 1.86901778e-11 cap_mim_2f0_m3m4_noshield A=9345.0889P P=386.68U
C$98 \$21 VDD 1.86901778e-11 cap_mim_2f0_m3m4_noshield A=9345.0889P P=386.68U
C$99 VSS VREF 1.67445e-11 cap_mim_2f0_m3m4_noshield A=8372.25P P=366U
C$100 VSS VREF 1.67445e-11 cap_mim_2f0_m3m4_noshield A=8372.25P P=366U
C$101 VSS VREF 1.67445e-11 cap_mim_2f0_m3m4_noshield A=8372.25P P=366U
C$102 VSS VREF 1.67445e-11 cap_mim_2f0_m3m4_noshield A=8372.25P P=366U
C$103 VSS VREF 1.67445e-11 cap_mim_2f0_m3m4_noshield A=8372.25P P=366U
.ENDS banba_layout
