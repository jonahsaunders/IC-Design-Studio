* NGSPICE file created from banba_layout.ext - technology: gf180mcuB

.subckt banba_layout VDD VREF VSS
X0 XAMP_NMIR XAMP_NMIR VSS VSS nfet_03v3 ad=3.2p pd=9.6u as=3.2p ps=9.6u w=4u l=2u
X1 VSS VSS VE2 pnp_05p00x05p00
**devattr s=1000000,4000
X2 CTRL XSTART_KICK VSS VSS nfet_03v3 ad=0.4p pd=2.6u as=0.4p ps=2.6u w=0.5u l=4u
X3 VB CTRL VDD VDD pfet_03v3 ad=6.4p pd=17.6u as=6.4p ps=17.6u w=8u l=4u
X4 XSTART_RDET_series_10 XSTART_RDET_series_9 VSS ppolyf_u_1k r_width=1u r_length=100u
X5 XSTART_RPULL_series_18 XSTART_RPULL_series_19 VSS ppolyf_u_1k r_width=1u r_length=100u
X6 XSTART_RDET_series_4 XSTART_RDET_series_3 VSS ppolyf_u_1k r_width=1u r_length=100u
X7 XAMP_RBIAS_series_2 XAMP_RBIAS_series_1 VSS ppolyf_u_1k r_width=1u r_length=100u
X8 VREF VSS cap_mim_2f0_m3m4_noshield c_width=90u c_length=90u
X9 XSTART_RPULL_series_12 XSTART_RPULL_series_13 VSS ppolyf_u_1k r_width=1u r_length=100u
X10 XAMP_RBIAS_series_8 XAMP_RBIAS_series_9 VSS ppolyf_u_1k r_width=1u r_length=100u
X11 VREF VSS cap_mim_2f0_m3m4_noshield c_width=90u c_length=90u
X12 VREF VSS VSS ppolyf_u_1k r_width=1u r_length=50.15u
X13 XSTART_RPULL_series_6 XSTART_RPULL_series_5 VSS ppolyf_u_1k r_width=1u r_length=100u
X14 VSS VSS VE2 pnp_05p00x05p00
**devattr s=1000000,4000
X15 VREF VSS cap_mim_2f0_m3m4_noshield c_width=90u c_length=90u
X16 VREF VSS cap_mim_2f0_m3m4_noshield c_width=90u c_length=90u
X17 XAMP_TAIL XAMP_PBIAS VDD VDD pfet_03v3 ad=6.4p pd=17.6u as=6.4p ps=17.6u w=8u l=4u
X18 XSTART_RDET_series_12 XSTART_RDET_series_11 VSS ppolyf_u_1k r_width=1u r_length=100u
X19 VA CTRL VDD VDD pfet_03v3 ad=6.4p pd=17.6u as=6.4p ps=17.6u w=8u l=4u
X20 VREF VSS cap_mim_2f0_m3m4_noshield c_width=90u c_length=90u
X21 XSTART_RPULL_series_14 XSTART_RPULL_series_13 VSS ppolyf_u_1k r_width=1u r_length=100u
X22 VDD CTRL cap_mim_2f0_m3m4_noshield c_width=96.67u c_length=96.67u
X23 XSTART_RPULL_series_8 XSTART_RPULL_series_7 VSS ppolyf_u_1k r_width=1u r_length=100u
X24 XSTART_RDET_series_6 XSTART_RDET_series_5 VSS ppolyf_u_1k r_width=1u r_length=100u
X25 XAMP_RBIAS_series_4 XAMP_RBIAS_series_3 VSS ppolyf_u_1k r_width=1u r_length=100u
X26 VREF VSS cap_mim_2f0_m3m4_noshield c_width=90u c_length=90u
X27 XSTART_DET CTRL VDD VDD pfet_03v3 ad=0.8p pd=3.6u as=0.8p ps=3.6u w=1u l=8u
X28 VREF VSS cap_mim_2f0_m3m4_noshield c_width=90u c_length=90u
X29 VDD XSTART_RPULL_series_1 VSS ppolyf_u_1k r_width=1u r_length=100u
X30 VSS VSS VA pnp_05p00x05p00
**devattr s=1000000,4000
X31 VREF VSS cap_mim_2f0_m3m4_noshield c_width=90u c_length=90u
X32 VREF CTRL VDD VDD pfet_03v3 ad=6.4p pd=17.6u as=6.4p ps=17.6u w=8u l=4u
X33 VSS VSS VE2 pnp_05p00x05p00
**devattr s=1000000,4000
X34 VREF VSS cap_mim_2f0_m3m4_noshield c_width=90u c_length=90u
X35 XSTART_RDET_series_14 XSTART_RDET_series_13 VSS ppolyf_u_1k r_width=1u r_length=100u
X36 VREF VSS cap_mim_2f0_m3m4_noshield c_width=90u c_length=90u
X37 XSTART_RDET_series_8 XSTART_RDET_series_7 VSS ppolyf_u_1k r_width=1u r_length=100u
X38 VREF VSS cap_mim_2f0_m3m4_noshield c_width=90u c_length=90u
X39 XSTART_RPULL_series_16 XSTART_RPULL_series_15 VSS ppolyf_u_1k r_width=1u r_length=100u
X40 XSTART_DET XSTART_RDET_series_1 VSS ppolyf_u_1k r_width=1u r_length=100u
X41 XSTART_RPULL_series_2 XSTART_RPULL_series_3 VSS ppolyf_u_1k r_width=1u r_length=100u
X42 XSTART_RPULL_series_10 XSTART_RPULL_series_9 VSS ppolyf_u_1k r_width=1u r_length=100u
X43 XAMP_RBIAS_series_6 XAMP_RBIAS_series_5 VSS ppolyf_u_1k r_width=1u r_length=100u
X44 VREF VSS cap_mim_2f0_m3m4_noshield c_width=90u c_length=90u
X45 VREF VSS cap_mim_2f0_m3m4_noshield c_width=90u c_length=90u
X46 XSTART_RDET_series_8 XSTART_RDET_series_9 VSS ppolyf_u_1k r_width=1u r_length=100u
X47 XSTART_RPULL_series_18 XSTART_RPULL_series_17 VSS ppolyf_u_1k r_width=1u r_length=100u
X48 VREF VSS cap_mim_2f0_m3m4_noshield c_width=90u c_length=90u
X49 VREF VSS cap_mim_2f0_m3m4_noshield c_width=90u c_length=90u
X50 XSTART_RDET_series_2 XSTART_RDET_series_3 VSS ppolyf_u_1k r_width=1u r_length=100u
X51 VSS XSTART_RDET_series_15 VSS ppolyf_u_1k r_width=1u r_length=100u
X52 VSS VSS VE2 pnp_05p00x05p00
**devattr s=1000000,4000
X53 VA VSS VSS ppolyf_u_1k r_width=1u r_length=100u
X54 VREF VSS cap_mim_2f0_m3m4_noshield c_width=90u c_length=90u
X55 XAMP_NMIR VA XAMP_TAIL VDD pfet_03v3 ad=19.2p pd=49.6u as=19.2p ps=49.6u w=24u l=2u
X56 XAMP_RBIAS_series_8 XAMP_RBIAS_series_7 VSS ppolyf_u_1k r_width=1u r_length=100u
X57 XSTART_RPULL_series_12 XSTART_RPULL_series_11 VSS ppolyf_u_1k r_width=1u r_length=100u
X58 VSS VSS VE2 pnp_05p00x05p00
**devattr s=1000000,4000
X59 XAMP_PBIAS XAMP_RBIAS_series_1 VSS ppolyf_u_1k r_width=1u r_length=100u
X60 XSTART_RPULL_series_4 XSTART_RPULL_series_5 VSS ppolyf_u_1k r_width=1u r_length=100u
X61 VSS VSS VE2 pnp_05p00x05p00
**devattr s=1000000,4000
X62 XAMP_GAIN XAMP_NMIR VSS VSS nfet_03v3 ad=3.2p pd=9.6u as=3.2p ps=9.6u w=4u l=2u
X63 VDD CTRL cap_mim_2f0_m3m4_noshield c_width=96.67u c_length=96.67u
X64 VREF VSS cap_mim_2f0_m3m4_noshield c_width=90u c_length=90u
X65 XSTART_RDET_series_10 XSTART_RDET_series_11 VSS ppolyf_u_1k r_width=1u r_length=100u
X66 XSTART_KICK XSTART_RPULL_series_19 VSS ppolyf_u_1k r_width=1u r_length=100u
X67 XSTART_RDET_series_4 XSTART_RDET_series_5 VSS ppolyf_u_1k r_width=1u r_length=100u
X68 XAMP_RBIAS_series_2 XAMP_RBIAS_series_3 VSS ppolyf_u_1k r_width=1u r_length=100u
X69 XSTART_RPULL_series_6 XSTART_RPULL_series_7 VSS ppolyf_u_1k r_width=1u r_length=100u
X70 VSS XAMP_RBIAS_series_9 VSS ppolyf_u_1k r_width=1u r_length=100u
X71 VREF VSS cap_mim_2f0_m3m4_noshield c_width=90u c_length=90u
X72 CTRL XAMP_PBIAS VDD VDD pfet_03v3 ad=3.2p pd=9.6u as=3.2p ps=9.6u w=4u l=8u
X73 VREF VSS cap_mim_2f0_m3m4_noshield c_width=90u c_length=90u
X74 VREF VSS cap_mim_2f0_m3m4_noshield c_width=90u c_length=90u
X75 VREF VSS cap_mim_2f0_m3m4_noshield c_width=90u c_length=90u
X76 XSTART_KICK XSTART_DET VSS VSS nfet_03v3 ad=6.4p pd=17.6u as=6.4p ps=17.6u w=8u l=1u
X77 XSTART_RDET_series_12 XSTART_RDET_series_13 VSS ppolyf_u_1k r_width=1u r_length=100u
X78 XAMP_GAIN VB XAMP_TAIL VDD pfet_03v3 ad=19.2p pd=49.6u as=19.2p ps=49.6u w=24u l=2u
X79 XSTART_RDET_series_6 XSTART_RDET_series_7 VSS ppolyf_u_1k r_width=1u r_length=100u
X80 XSTART_RPULL_series_14 XSTART_RPULL_series_15 VSS ppolyf_u_1k r_width=1u r_length=100u
X81 VSS VSS VE2 pnp_05p00x05p00
**devattr s=1000000,4000
X82 XSTART_RPULL_series_2 XSTART_RPULL_series_1 VSS ppolyf_u_1k r_width=1u r_length=100u
X83 VSS VSS VE2 pnp_05p00x05p00
**devattr s=1000000,4000
X84 XAMP_RBIAS_series_4 XAMP_RBIAS_series_5 VSS ppolyf_u_1k r_width=1u r_length=100u
X85 XSTART_RPULL_series_8 XSTART_RPULL_series_9 VSS ppolyf_u_1k r_width=1u r_length=100u
X86 VB VSS VSS ppolyf_u_1k r_width=1u r_length=100u
X87 VREF VSS cap_mim_2f0_m3m4_noshield c_width=90u c_length=90u
X88 XAMP_PBIAS XAMP_PBIAS VDD VDD pfet_03v3 ad=3.2p pd=9.6u as=3.2p ps=9.6u w=4u l=4u
X89 VDD CTRL cap_mim_2f0_m3m4_noshield c_width=96.67u c_length=96.67u
X90 XAMP_GAIN CTRL cap_mim_2f0_m3m4_noshield c_width=44.72u c_length=44.72u
X91 VB VE2 VSS ppolyf_u_1k r_width=1u r_length=10.85u
X92 XSTART_RDET_series_14 XSTART_RDET_series_15 VSS ppolyf_u_1k r_width=1u r_length=100u
X93 XSTART_RPULL_series_16 XSTART_RPULL_series_17 VSS ppolyf_u_1k r_width=1u r_length=100u
X94 VREF VSS cap_mim_2f0_m3m4_noshield c_width=90u c_length=90u
X95 XSTART_RDET_series_2 XSTART_RDET_series_1 VSS ppolyf_u_1k r_width=1u r_length=100u
X96 CTRL XAMP_GAIN VSS VSS nfet_03v3 ad=3.2p pd=9.6u as=3.2p ps=9.6u w=4u l=2u
X97 XAMP_RBIAS_series_6 XAMP_RBIAS_series_7 VSS ppolyf_u_1k r_width=1u r_length=100u
X98 VREF VSS cap_mim_2f0_m3m4_noshield c_width=90u c_length=90u
X99 XSTART_RPULL_series_4 XSTART_RPULL_series_3 VSS ppolyf_u_1k r_width=1u r_length=100u
X100 VREF VSS cap_mim_2f0_m3m4_noshield c_width=90u c_length=90u
X101 VDD CTRL cap_mim_2f0_m3m4_noshield c_width=96.67u c_length=96.67u
X102 XSTART_RPULL_series_10 XSTART_RPULL_series_11 VSS ppolyf_u_1k r_width=1u r_length=100u
C0 XAMP_RBIAS_series_3 XAMP_RBIAS_series_5 0.00522f
C1 XAMP_RBIAS_series_3 XSTART_KICK 0.003f
C2 XAMP_GAIN CTRL 4.26002f
C3 XSTART_DET CTRL 0.49804f
C4 CTRL XAMP_RBIAS_series_5 0.00684f
C5 XSTART_RPULL_series_9 XSTART_RPULL_series_7 0.00522f
C6 XSTART_RPULL_series_4 XSTART_KICK 0.00565f
C7 CTRL XSTART_KICK 0.57071f
C8 XAMP_TAIL VA 1.48956f
C9 VDD XSTART_RDET_series_10 0
C10 XSTART_RPULL_series_15 XSTART_RPULL_series_13 0.00522f
C11 CTRL XAMP_RBIAS_series_7 0.00684f
C12 VDD VB 3.08737f
C13 VDD VE2 2.71432f
C14 XSTART_RPULL_series_1 XSTART_RPULL_series_3 0.00522f
C15 VREF VB 0.23884f
C16 XSTART_RPULL_series_6 XSTART_KICK 0.00565f
C17 VREF VE2 4.25544f
C18 XSTART_RPULL_series_14 XSTART_RPULL_series_16 0.00522f
C19 XAMP_NMIR VB 0.12274f
C20 VA CTRL 3.13491f
C21 XSTART_RPULL_series_14 XSTART_KICK 0.00565f
C22 XAMP_NMIR VE2 0.45655f
C23 XAMP_RBIAS_series_9 XSTART_KICK 0.003f
C24 XAMP_GAIN XAMP_PBIAS 0.89368f
C25 XSTART_DET XAMP_PBIAS 1.96692f
C26 XAMP_TAIL CTRL 0.35791f
C27 XSTART_RDET_series_11 XSTART_RDET_series_13 0.00522f
C28 XSTART_RDET_series_7 XSTART_RDET_series_9 0.00522f
C29 XAMP_PBIAS XSTART_KICK 0.17168f
C30 XAMP_RBIAS_series_9 XAMP_RBIAS_series_7 0.00522f
C31 XSTART_RDET_series_4 XSTART_RDET_series_2 0.00522f
C32 CTRL XAMP_RBIAS_series_3 0.00684f
C33 XSTART_RPULL_series_11 XSTART_RPULL_series_9 0.00522f
C34 VA XAMP_PBIAS 0.56851f
C35 XSTART_RDET_series_5 XSTART_RDET_series_3 0.00522f
C36 VDD XSTART_RPULL_series_2 0.00814f
C37 VB VE2 0.1132f
C38 XAMP_TAIL XAMP_PBIAS 2.8715f
C39 XAMP_GAIN VDD 0.91007f
C40 VDD XSTART_DET 0.31394f
C41 XSTART_RPULL_series_4 XSTART_RPULL_series_6 0.00522f
C42 VREF XAMP_GAIN 0.48555f
C43 VREF XSTART_DET 0.33733f
C44 XSTART_RDET_series_8 XSTART_RDET_series_6 0.00522f
C45 CTRL XAMP_RBIAS_series_9 0.00684f
C46 VDD XSTART_KICK 0.207f
C47 XAMP_GAIN XAMP_NMIR 2.66296f
C48 VREF XSTART_KICK 0.36323f
C49 XSTART_RPULL_series_12 XSTART_KICK 0.00565f
C50 CTRL XAMP_PBIAS 0.87264f
C51 XSTART_RDET_series_12 XSTART_RDET_series_14 0.00522f
C52 VDD XSTART_RDET_series_2 0
C53 XSTART_RPULL_series_5 XSTART_RPULL_series_7 0.00522f
C54 XSTART_RPULL_series_5 XSTART_RPULL_series_3 0.00522f
C55 VDD XSTART_RDET_series_8 0
C56 VDD VA 3.85923f
C57 VREF VA 0.24063f
C58 VA XAMP_NMIR 1.59672f
C59 XSTART_RPULL_series_12 XSTART_RPULL_series_10 0.00522f
C60 VDD XAMP_TAIL 3.50353f
C61 VREF XAMP_TAIL 0.37982f
C62 XAMP_GAIN VB 1.31535f
C63 XAMP_GAIN VE2 1.02418f
C64 XSTART_DET VE2 0.34437f
C65 XAMP_TAIL XAMP_NMIR 0.91543f
C66 XSTART_KICK VE2 0.37028f
C67 VDD CTRL 41.7781f
C68 XSTART_RDET_series_8 XSTART_RDET_series_10 0.00522f
C69 VREF CTRL 0.51775f
C70 CTRL XAMP_NMIR 0.52226f
C71 XSTART_RDET_series_4 XSTART_RDET_series_6 0.00522f
C72 VDD XSTART_RDET_series_12 0
C73 XSTART_RDET_series_15 XSTART_RDET_series_13 0.00522f
C74 VDD XSTART_RDET_series_14 0
C75 VA VB 1.3257f
C76 XSTART_RPULL_series_15 XSTART_RPULL_series_17 0.00522f
C77 VA VE2 1.57474f
C78 XSTART_RPULL_series_19 XSTART_RPULL_series_17 0.00522f
C79 XSTART_RPULL_series_8 XSTART_KICK 0.00565f
C80 XAMP_RBIAS_series_8 XAMP_RBIAS_series_6 0.00522f
C81 XAMP_RBIAS_series_2 XAMP_PBIAS 0.00814f
C82 XAMP_TAIL VB 1.44849f
C83 XSTART_RDET_series_4 VDD 0
C84 XAMP_TAIL VE2 0.37982f
C85 XSTART_RPULL_series_14 XSTART_RPULL_series_12 0.00522f
C86 VDD XAMP_PBIAS 6.35784f
C87 XAMP_RBIAS_series_1 XSTART_KICK 0.003f
C88 VREF XAMP_PBIAS 0.5748f
C89 XSTART_RDET_series_5 XSTART_RDET_series_7 0.00522f
C90 XAMP_NMIR XAMP_PBIAS 1.34772f
C91 XSTART_RPULL_series_2 XSTART_KICK 0.00565f
C92 XAMP_GAIN XSTART_DET 0.36529f
C93 CTRL VB 0.95464f
C94 CTRL VE2 0.7236f
C95 XSTART_RPULL_series_8 XSTART_RPULL_series_10 0.00522f
C96 XSTART_RDET_series_11 XSTART_RDET_series_9 0.00522f
C97 XAMP_GAIN XSTART_KICK 0.38352f
C98 XSTART_DET XSTART_KICK 4.68133f
C99 XAMP_RBIAS_series_4 XAMP_RBIAS_series_6 0.00522f
C100 XSTART_RPULL_series_16 XSTART_KICK 0.00565f
C101 XSTART_RDET_series_12 XSTART_RDET_series_10 0.00522f
C102 XSTART_KICK XAMP_RBIAS_series_5 0.003f
C103 VDD XSTART_RDET_series_6 0
C104 XSTART_DET XSTART_RDET_series_2 0.00814f
C105 XAMP_RBIAS_series_5 XAMP_RBIAS_series_7 0.00522f
C106 XSTART_KICK XAMP_RBIAS_series_7 0.003f
C107 XSTART_RPULL_series_18 XSTART_RPULL_series_16 0.00522f
C108 XAMP_GAIN VA 0.51094f
C109 XSTART_RPULL_series_11 XSTART_RPULL_series_13 0.00522f
C110 XSTART_DET VA 0.34755f
C111 XSTART_RPULL_series_18 XSTART_KICK 0.01855f
C112 XAMP_RBIAS_series_2 XAMP_RBIAS_series_4 0.00522f
C113 XAMP_PBIAS VB 3.60943f
C114 VREF VDD 0.75003f
C115 VA XSTART_KICK 0.37346f
C116 XAMP_RBIAS_series_1 XAMP_RBIAS_series_3 0.00522f
C117 XAMP_PBIAS VE2 0.5748f
C118 XSTART_RPULL_series_10 XSTART_KICK 0.00565f
C119 XSTART_RDET_series_3 XSTART_RDET_series_1 0.00522f
C120 VDD XAMP_NMIR 1.10915f
C121 XAMP_GAIN XAMP_TAIL 0.96692f
C122 XSTART_DET XAMP_TAIL 1.7243f
C123 CTRL XAMP_RBIAS_series_1 0.00684f
C124 VREF XAMP_NMIR 0.46691f
C125 XAMP_TAIL XSTART_KICK 0.13254f
C126 XSTART_RPULL_series_4 XSTART_RPULL_series_2 0.00522f
C127 XSTART_RPULL_series_8 XSTART_RPULL_series_6 0.00522f
C128 CTRL VSS 0.47601p
C129 XAMP_TAIL VSS 90.65318f
C130 XSTART_RDET_series_1 VSS 0.79894f
C131 XSTART_RDET_series_2 VSS 0.76813f
C132 XSTART_RDET_series_3 VSS 0.78892f
C133 XSTART_RDET_series_4 VSS 0.76821f
C134 XSTART_RDET_series_5 VSS 0.78892f
C135 VE2 VSS 1.41888p
C136 XSTART_RDET_series_6 VSS 0.76821f
C137 XSTART_RDET_series_7 VSS 0.78892f
C138 XSTART_RDET_series_8 VSS 0.76821f
C139 XSTART_RDET_series_9 VSS 0.78892f
C140 XSTART_RDET_series_10 VSS 0.76821f
C141 XSTART_RDET_series_11 VSS 0.78892f
C142 XAMP_RBIAS_series_1 VSS 0.79894f
C143 XSTART_RDET_series_12 VSS 0.76821f
C144 XAMP_RBIAS_series_2 VSS 0.76813f
C145 XSTART_RDET_series_13 VSS 0.78892f
C146 XAMP_RBIAS_series_3 VSS 0.78892f
C147 XSTART_RDET_series_14 VSS 0.78103f
C148 XAMP_RBIAS_series_4 VSS 0.76821f
C149 XSTART_RDET_series_15 VSS 0.79894f
C150 XAMP_RBIAS_series_5 VSS 0.78892f
C151 XAMP_RBIAS_series_6 VSS 0.76821f
C152 XAMP_RBIAS_series_7 VSS 0.78892f
C153 XAMP_RBIAS_series_8 VSS 0.78103f
C154 XAMP_RBIAS_series_9 VSS 0.79894f
C155 XSTART_RPULL_series_1 VSS 0.79894f
C156 XSTART_RPULL_series_2 VSS 0.76248f
C157 XSTART_RPULL_series_3 VSS 0.78892f
C158 XSTART_RPULL_series_4 VSS 0.76256f
C159 XSTART_RPULL_series_5 VSS 0.78892f
C160 XSTART_RPULL_series_6 VSS 0.76256f
C161 XSTART_RPULL_series_7 VSS 0.78892f
C162 XSTART_RPULL_series_8 VSS 0.76256f
C163 XSTART_RPULL_series_9 VSS 0.78892f
C164 XSTART_RPULL_series_10 VSS 0.76256f
C165 XSTART_RPULL_series_11 VSS 0.78892f
C166 XSTART_RPULL_series_12 VSS 0.76256f
C167 XSTART_RPULL_series_13 VSS 0.78892f
C168 XSTART_RPULL_series_14 VSS 0.76256f
C169 XSTART_RPULL_series_15 VSS 0.78892f
C170 XSTART_RPULL_series_16 VSS 0.76256f
C171 XSTART_RPULL_series_17 VSS 0.78892f
C172 XSTART_RPULL_series_18 VSS 0.76248f
C173 XSTART_RPULL_series_19 VSS 0.79894f
C174 XSTART_KICK VSS 0.18785p
.ends
