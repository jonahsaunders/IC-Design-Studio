* Extracted by KLayout with GF180MCU LVS runset on : 28/09/2026 09:05

.SUBCKT banba_layout VSS VREF VDD
M$1 \$574420 \$601319 VDD VDD pfet_03v3 L=8U W=1U AS=0.8P AD=0.8P PS=3.6U
+ PD=3.6U
M$2 \$578442 \$578442 VDD VDD pfet_03v3 L=4U W=4U AS=3.2P AD=3.2P PS=9.6U
+ PD=9.6U
M$3 \$601319 \$578442 VDD VDD pfet_03v3 L=8U W=4U AS=3.2P AD=3.2P PS=9.6U
+ PD=9.6U
M$4 \$618102 \$601319 VDD VDD pfet_03v3 L=4U W=8U AS=6.4P AD=6.4P PS=17.6U
+ PD=17.6U
M$5 \$595759 \$601319 VDD VDD pfet_03v3 L=4U W=8U AS=6.4P AD=6.4P PS=17.6U
+ PD=17.6U
M$6 VREF \$601319 VDD VDD pfet_03v3 L=4U W=8U AS=6.4P AD=6.4P PS=17.6U PD=17.6U
M$7 \$606880 \$578442 VDD VDD pfet_03v3 L=4U W=8U AS=6.4P AD=6.4P PS=17.6U
+ PD=17.6U
M$8 \$582349 \$618102 \$606880 VDD pfet_03v3 L=2U W=24U AS=19.2P AD=19.2P
+ PS=49.6U PD=49.6U
M$9 \$584302 \$595759 \$606880 VDD pfet_03v3 L=2U W=24U AS=19.2P AD=19.2P
+ PS=49.6U PD=49.6U
M$10 \$601319 \$571633 VSS VSS nfet_03v3 L=4U W=0.5U AS=0.4P AD=0.4P PS=2.6U
+ PD=2.6U
M$11 \$582349 \$582349 VSS VSS nfet_03v3 L=2U W=4U AS=3.2P AD=3.2P PS=9.6U
+ PD=9.6U
M$12 \$584302 \$582349 VSS VSS nfet_03v3 L=2U W=4U AS=3.2P AD=3.2P PS=9.6U
+ PD=9.6U
M$13 \$601319 \$584302 VSS VSS nfet_03v3 L=2U W=4U AS=3.2P AD=3.2P PS=9.6U
+ PD=9.6U
M$14 \$571633 \$574420 VSS VSS nfet_03v3 L=1U W=8U AS=6.4P AD=6.4P PS=17.6U
+ PD=17.6U
Q$15 VSS VSS \$608739 pnp_05p00x05p00 AE=25P PE=20U AB=41.9904P PB=25.92U
+ AC=41.9904P PC=25.92U NE=1
Q$16 VSS VSS \$608739 pnp_05p00x05p00 AE=25P PE=20U AB=41.9904P PB=25.92U
+ AC=41.9904P PC=25.92U NE=1
Q$17 VSS VSS \$608739 pnp_05p00x05p00 AE=25P PE=20U AB=41.9904P PB=25.92U
+ AC=41.9904P PC=25.92U NE=1
Q$18 VSS VSS \$608739 pnp_05p00x05p00 AE=25P PE=20U AB=41.9904P PB=25.92U
+ AC=41.9904P PC=25.92U NE=1
Q$19 VSS VSS \$608739 pnp_05p00x05p00 AE=25P PE=20U AB=41.9904P PB=25.92U
+ AC=41.9904P PC=25.92U NE=1
Q$20 VSS VSS \$618102 pnp_05p00x05p00 AE=25P PE=20U AB=41.9904P PB=25.92U
+ AC=41.9904P PC=25.92U NE=1
Q$21 VSS VSS \$608739 pnp_05p00x05p00 AE=25P PE=20U AB=41.9904P PB=25.92U
+ AC=41.9904P PC=25.92U NE=1
Q$22 VSS VSS \$608739 pnp_05p00x05p00 AE=25P PE=20U AB=41.9904P PB=25.92U
+ AC=41.9904P PC=25.92U NE=1
Q$23 VSS VSS \$608739 pnp_05p00x05p00 AE=25P PE=20U AB=41.9904P PB=25.92U
+ AC=41.9904P PC=25.92U NE=1
R$24 \$618102 VSS VSS 100000 ppolyf_u_1k L=100U W=1U
R$25 \$595759 VSS VSS 100000 ppolyf_u_1k L=100U W=1U
R$26 \$651844 \$648085 VSS 100000 ppolyf_u_1k L=100U W=1U
R$27 \$651844 \$653744 VSS 100000 ppolyf_u_1k L=100U W=1U
R$28 \$574420 \$648085 VSS 100000 ppolyf_u_1k L=100U W=1U
R$29 \$655638 \$653744 VSS 100000 ppolyf_u_1k L=100U W=1U
R$30 \$655638 \$657537 VSS 100000 ppolyf_u_1k L=100U W=1U
R$31 \$595759 \$608739 VSS 10850 ppolyf_u_1k L=10.85U W=1U
R$32 VREF VSS VSS 50150 ppolyf_u_1k L=50.15U W=1U
R$33 \$661328 \$657537 VSS 100000 ppolyf_u_1k L=100U W=1U
R$34 \$661328 \$663249 VSS 100000 ppolyf_u_1k L=100U W=1U
R$35 \$665148 \$667043 VSS 100000 ppolyf_u_1k L=100U W=1U
R$36 \$665148 \$663249 VSS 100000 ppolyf_u_1k L=100U W=1U
R$37 \$670868 \$667043 VSS 100000 ppolyf_u_1k L=100U W=1U
R$38 \$578442 \$672770 VSS 100000 ppolyf_u_1k L=100U W=1U
R$39 \$670868 \$672771 VSS 100000 ppolyf_u_1k L=100U W=1U
R$40 \$674670 \$672770 VSS 100000 ppolyf_u_1k L=100U W=1U
R$41 \$674671 \$672771 VSS 100000 ppolyf_u_1k L=100U W=1U
R$42 \$674670 \$676574 VSS 100000 ppolyf_u_1k L=100U W=1U
R$43 \$674671 \$676575 VSS 100000 ppolyf_u_1k L=100U W=1U
R$44 \$680374 \$676574 VSS 100000 ppolyf_u_1k L=100U W=1U
R$45 \$680375 \$676575 VSS 100000 ppolyf_u_1k L=100U W=1U
R$46 \$680374 \$682274 VSS 100000 ppolyf_u_1k L=100U W=1U
R$47 \$680375 \$682275 VSS 100000 ppolyf_u_1k L=100U W=1U
R$48 \$684178 \$682274 VSS 100000 ppolyf_u_1k L=100U W=1U
R$49 VSS \$682275 VSS 100000 ppolyf_u_1k L=100U W=1U
R$50 \$684178 \$686077 VSS 100000 ppolyf_u_1k L=100U W=1U
R$51 \$689895 \$686077 VSS 100000 ppolyf_u_1k L=100U W=1U
R$52 \$689895 \$691797 VSS 100000 ppolyf_u_1k L=100U W=1U
R$53 VSS \$691797 VSS 100000 ppolyf_u_1k L=100U W=1U
R$54 VDD \$695596 VSS 100000 ppolyf_u_1k L=100U W=1U
R$55 \$699394 \$695596 VSS 100000 ppolyf_u_1k L=100U W=1U
R$56 \$699394 \$701292 VSS 100000 ppolyf_u_1k L=100U W=1U
R$57 \$703194 \$701292 VSS 100000 ppolyf_u_1k L=100U W=1U
R$58 \$703194 \$705092 VSS 100000 ppolyf_u_1k L=100U W=1U
R$59 \$708910 \$705092 VSS 100000 ppolyf_u_1k L=100U W=1U
R$60 \$708910 \$710812 VSS 100000 ppolyf_u_1k L=100U W=1U
R$61 \$712718 \$710812 VSS 100000 ppolyf_u_1k L=100U W=1U
R$62 \$712718 \$714628 VSS 100000 ppolyf_u_1k L=100U W=1U
R$63 \$718521 \$714628 VSS 100000 ppolyf_u_1k L=100U W=1U
R$64 \$718521 \$720467 VSS 100000 ppolyf_u_1k L=100U W=1U
R$65 \$722416 \$720467 VSS 100000 ppolyf_u_1k L=100U W=1U
R$66 \$722416 \$724382 VSS 100000 ppolyf_u_1k L=100U W=1U
R$67 \$728275 \$724382 VSS 100000 ppolyf_u_1k L=100U W=1U
R$68 \$728275 \$730224 VSS 100000 ppolyf_u_1k L=100U W=1U
R$69 \$732195 \$730224 VSS 100000 ppolyf_u_1k L=100U W=1U
R$70 \$732195 \$734144 VSS 100000 ppolyf_u_1k L=100U W=1U
R$71 \$738037 \$734144 VSS 100000 ppolyf_u_1k L=100U W=1U
R$72 \$738037 \$739983 VSS 100000 ppolyf_u_1k L=100U W=1U
R$73 \$571633 \$739983 VSS 100000 ppolyf_u_1k L=100U W=1U
C$74 VSS VREF 1.67445e-11 cap_mim_2f0_m3m4_noshield A=8372.25P P=366U
C$75 VSS VREF 1.67445e-11 cap_mim_2f0_m3m4_noshield A=8372.25P P=366U
C$76 VSS VREF 1.67445e-11 cap_mim_2f0_m3m4_noshield A=8372.25P P=366U
C$77 VSS VREF 1.67445e-11 cap_mim_2f0_m3m4_noshield A=8372.25P P=366U
C$78 VSS VREF 1.67445e-11 cap_mim_2f0_m3m4_noshield A=8372.25P P=366U
C$79 VSS VREF 1.67445e-11 cap_mim_2f0_m3m4_noshield A=8372.25P P=366U
C$80 VSS VREF 1.67445e-11 cap_mim_2f0_m3m4_noshield A=8372.25P P=366U
C$81 VSS VREF 1.67445e-11 cap_mim_2f0_m3m4_noshield A=8372.25P P=366U
C$82 VSS VREF 1.67445e-11 cap_mim_2f0_m3m4_noshield A=8372.25P P=366U
C$83 VSS VREF 1.67445e-11 cap_mim_2f0_m3m4_noshield A=8372.25P P=366U
C$84 VSS VREF 1.67445e-11 cap_mim_2f0_m3m4_noshield A=8372.25P P=366U
C$85 VSS VREF 1.67445e-11 cap_mim_2f0_m3m4_noshield A=8372.25P P=366U
C$86 VSS VREF 1.67445e-11 cap_mim_2f0_m3m4_noshield A=8372.25P P=366U
C$87 VSS VREF 1.67445e-11 cap_mim_2f0_m3m4_noshield A=8372.25P P=366U
C$88 VSS VREF 1.67445e-11 cap_mim_2f0_m3m4_noshield A=8372.25P P=366U
C$89 \$601319 \$584302 3.9997568e-12 cap_mim_2f0_m3m4_noshield A=1999.8784P
+ P=178.88U
C$90 \$601319 VDD 1.86901778e-11 cap_mim_2f0_m3m4_noshield A=9345.0889P
+ P=386.68U
C$91 \$601319 VDD 1.86901778e-11 cap_mim_2f0_m3m4_noshield A=9345.0889P
+ P=386.68U
C$92 VSS VREF 1.67445e-11 cap_mim_2f0_m3m4_noshield A=8372.25P P=366U
C$93 VSS VREF 1.67445e-11 cap_mim_2f0_m3m4_noshield A=8372.25P P=366U
C$94 VSS VREF 1.67445e-11 cap_mim_2f0_m3m4_noshield A=8372.25P P=366U
C$95 VSS VREF 1.67445e-11 cap_mim_2f0_m3m4_noshield A=8372.25P P=366U
C$96 VSS VREF 1.67445e-11 cap_mim_2f0_m3m4_noshield A=8372.25P P=366U
C$97 \$601319 VDD 1.86901778e-11 cap_mim_2f0_m3m4_noshield A=9345.0889P
+ P=386.68U
C$98 \$601319 VDD 1.86901778e-11 cap_mim_2f0_m3m4_noshield A=9345.0889P
+ P=386.68U
C$99 VSS VREF 1.67445e-11 cap_mim_2f0_m3m4_noshield A=8372.25P P=366U
C$100 VSS VREF 1.67445e-11 cap_mim_2f0_m3m4_noshield A=8372.25P P=366U
C$101 VSS VREF 1.67445e-11 cap_mim_2f0_m3m4_noshield A=8372.25P P=366U
C$102 VSS VREF 1.67445e-11 cap_mim_2f0_m3m4_noshield A=8372.25P P=366U
C$103 VSS VREF 1.67445e-11 cap_mim_2f0_m3m4_noshield A=8372.25P P=366U
.ENDS banba_layout
