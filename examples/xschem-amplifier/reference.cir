* Independently authored common-source reference
VDD vdd 0 1.8
VIN vin 0 DC 0.8 AC 1
XAMP vin vout vdd 0 gain resistance=8k width=12u
CL vout 0 1p
.subckt gain in out vdd vss resistance=10k width=10u
RD vdd out {resistance}
M1 out in vss vss nch w={width} l=1u
.ends gain
.model nch nmos (level=1 vto=0.45 kp=100u lambda=0.02)
.ac dec 20 10 10meg
.end
