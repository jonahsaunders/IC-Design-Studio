* NGSPICE file created from coupon.ext - technology: ihp-sg13g2

.subckt coupon C1 C2
X0 C1 C2 cap_cmim l=7u w=7u
X1 C1 C2 cap_cmim l=7u w=7u
C0 C2 C1 0.92804f
C1 C1 SUB 1.48762f
C2 C2 SUB 2.24584f
.ends
